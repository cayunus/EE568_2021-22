# Ansys Electronics Desktop project, version 2020.2
materials:
  copper_75C: permeability=0.999991 conductivity=46000000
  M22_24G: permeability{HUnit=A_per_meter BUnit=tesla curve (0, 0) (160, 0.8) (240, 1) (320, 1.1) (420, 1.2) (680, 1.3) (810, 1.325) (1100, 1.375) (1400, 1.4) (2600, 1.475) (4200, 1.54) (5087.91, 1.575) (6579.41, 1.625) (8231.91, 1.675) (10258.9, 1.725) (13348.9, 1.775) (18788.9, 1.825) (28908.9, 1.875) (46508.9, 1.925) (74308.9, 1.975) (129350, 2.05) (248716, 2.2) (447658, 2.45) (726178, 2.8)} conductivity=2000000 core_loss_type="Electrical Steel" core_loss_kh=177.7 core_loss_kc=1.33 core_loss_ke=1.22 mass_density=7650
  steel_1008: permeability{HUnit=A_per_meter BUnit=tesla curve (0, 0) (159.2, 0.2402) (318.3, 0.8654) (477.5, 1.1106) (636.6, 1.2458) (795.8, 1.331) (1591.5, 1.5) (3183.1, 1.6) (4774.6, 1.683) (6366.2, 1.741) (7957.7, 1.78) (15915.5, 1.905) (31831, 2.025) (47746.5, 2.085) (63662, 2.13) (79577.5, 2.165) (159155, 2.28) (318310, 2.485) (397887, 2.5851)} conductivity=2000000 mass_density=7872
  vacuum: permittivity=1
  M22_24G_2DSF0.781: permeability{HUnit=A_per_meter BUnit=tesla curve (0, 0) (160, 0.624913) (240, 0.781153) (320, 0.859283) (420, 0.93742) (680, 1.0156) (810, 1.03516) (1100, 1.0743) (1400, 1.09391) (2600, 1.15282) (4200, 1.20403) (5087.91, 1.23161) (6579.41, 1.27108) (8231.91, 1.31058) (10258.9, 1.3502) (13348.9, 1.3901) (18788.9, 1.43065) (28908.9, 1.47249) (46508.9, 1.51639) (74308.9, 1.56309) (129350, 1.63681) (248716, 1.78681) (447658, 2.03681) (726178, 2.38681) (3511380, 5.88681)} conductivity=2000000 core_loss_type="Electrical Steel" core_loss_kh=227.504 core_loss_kc=1.70276 core_loss_ke=1.38042 mass_density=5975.31
  steel_1008_2DSF0.995: permeability{HUnit=A_per_meter BUnit=tesla curve (0, 0) (159.2, 0.238956) (318.3, 0.860917) (477.5, 1.10485) (636.6, 1.23935) (795.8, 1.32411) (1591.5, 1.49224) (3183.1, 1.59173) (4774.6, 1.67431) (6366.2, 1.73202) (7957.7, 1.77083) (15915.5, 1.89523) (31831, 2.01471) (47746.5, 2.0745) (63662, 2.11937) (79577.5, 2.1543) (159155, 2.26922) (318310, 2.47419) (397887, 2.57429) (1193660, 3.57529)} conductivity=2000000 mass_density=7831.2
  copper_115C: conductivity=40742900
  copper: permeability=0.999991 conductivity=58000000 mass_density=8933

design bjs10-61 (RMxprt, Three Phase Synchronous Machine, model units mm)
machine:
  Machine: FrictionLoss=9050W WindLoss=0W ReferenceSpeed=1000rpm NumberOfPoles=6
  Stator: SkewWidth=0 NumberOfSlots=72 LaminationSectors=1 PressBoardThickness=0mm OuterDiameter=1102.2mm InnerDiameter=762mm Length=760mm StackingFactor=0.9 SteelType=M22_24G SlotType=6
  Rotor: OuterDiameter=749mm InnerDiameter=250mm Length=760mm SteelType=steel_1008 SecondAirGap=0mm PoleBodyHeight=147mm PoleShoeHeight=53mm Off2x=0mm Off2y=0mm PoleArcOffset=43mm PoleBodyWidth=146mm PoleShoeWidth=280mm PoleStackingFactor=0.96 PoleSteelType=steel_1008 PressBoardThickness=40mm StackingFactor=0.96 ShoeInsulation=3mm PoleInsulation=3mm WindingClearance=10mm
  Shaft:
  Stator Slot: Hs0=0.8mm Hs1=3.2mm Hs2=67mm Bs0=0mm Bs1=14.7mm Bs2=14.7mm Rs=0mm ToothWidth=0mm
  Stator Winding: WindingType=Whole-Coiled WindingLayers=2 ParallelBranches=1 ConductorsPerSlot=10 CoilPitch=10 EndAdjustment=105mm BaseInnerRadius=0mm TipInnerDiameter=30mm EndClearance=5mm CoilWrap=2mm SlotLiner=0.1mm WedgeThickness=3.2mm LayerInsulation=2mm BottomInsulation=0mm LimitedFillFactor=0.75 WdgNumberofPriodicMultipler=1 NumberOfStrands=2 WireWrap=0.4mm InterturnInsulation=0mm WireDiameter=0mm WireWidth=9.5mm WireThickness=2.36mm Gauge=STANDARDRECT
  Rotor Winding: WindingType=EdgewiseCoil ParallelBranches=1 ConductorsPerPole=135 AxialClearance=0mm LimitedCrossWidth=0mm LimitedCrossHeight=130mm NumberOfStrands=1 WireWrap=0.4mm InterturnInsulation=0mm WireDiameter=0mm WireWidth=45mm WireThickness=1.6mm Gauge=USER WindingFillet=76mm
  Stator Vent: VentDucts=13 DuctWidth=9.5mm MagneticSpacerWidth=0mm DuctPitch=0mm
  Rotor Damper: DamperSlotsPerPole=6 SlotType=1 BarConductorType=copper_75C EndLength=0mm EndRingWidth=12.5mm EndRingHeight=21mm EndRingConductorType=copper_75C SlotPitch=5.064deg CenterSlotPitch=14.736deg EndRingType=1
  Damper Slot: Hs0=0.8mm Hs1=0mm Hs2=0mm Bs0=3mm Bs1=14mm Bs2=14mm Rs=0mm Hs01=0mm
setups:
  Setup1: SYNM Generator RatedOutputPower=2400 RatedVoltage=6600V RatedSpeed=1000rpm OperatingTemperature=115cel LoadType=InfiniteBus RatedPowerFactor=0.8 ExciterEfficiency=80 StartingFieldResistance=0ohm

design Maxwell2DDesign1 (Maxwell 2D, Transient, XY geometry, model units mm)
options: ComputeTransientInductance ModelDepth=733.401mm
variables:
  fractions = 3
  delta = -28.514674deg
  conds = 5
  R1 = 0.20278775ohm
  Le1 = 0.0023052267H
geometry:
  Band [vacuum] = user_primitive(RMxprt/Band, DiaGap=755.5mm, DiaYoke=250mm, Length=0mm, SegAngle=0deg, Fractions=1, HalfAxial=0, InfoCore=0)
  Shaft [vacuum] = user_primitive(RMxprt/Band, DiaGap=755.5mm, DiaYoke=250mm, Length=0mm, SegAngle=0deg, Fractions=1, HalfAxial=0, InfoCore=100)
  OuterRegion [vacuum] = user_primitive(RMxprt/Band, DiaGap=755.5mm, DiaYoke=1102.2mm, Length=0mm, SegAngle=0deg, Fractions=fractions, HalfAxial=0, InfoCore=100)
  Tool = user_primitive(RMxprt/Band, DiaGap=755.5mm, DiaYoke=1102.2mm, Length=0mm, SegAngle=0deg, Fractions=fractions, HalfAxial=0, InfoCore=1)
  Stator [M22_24G_2DSF0.781] = user_primitive(RMxprt/SlotCore, DiaGap=762mm, DiaYoke=1102.2mm, Length=0mm, Skew=0deg, Slots=72, SlotType=6, Hs0=0.8mm, Hs01=0mm, Hs1=3.2mm, Hs2=67mm, Bs0=14.7mm, Bs1=14.7mm, Bs2=14.7mm, Rs=0mm, FilletType=0, HalfSlot=0, SegAngle=15deg, LenRegion=0mm, InfoCore=0)
  Coil_0 [copper] = user_primitive(RMxprt/LapCoil, DiaGap=762mm, DiaYoke=1102.2mm, Length=0mm, Skew=0deg, Slots=72, SlotType=6, Hs0=0.8mm, Hs1=3.2mm, Hs2=67mm, Bs0=14.7mm, Bs1=14.7mm, Bs2=14.7mm, Rs=0mm, FilletType=0, Layers=2, CoilPitch=10, EndExt=105mm, SpanExt=0mm, BendAngle=0deg, SegAngle=10deg, LenRegion=0mm, InfoCoil=2)
  Coil_1..Coil_23 [copper], Coil_24..Coil_71 = Coil_0.duplicate_around_axis(axis=Z, angle=5deg, total=72)
  Coil_0.unite(Coil_24, Coil_48)
  Coil_1.unite(Coil_25, Coil_49)
  Coil_2.unite(Coil_26, Coil_50)
  Coil_3.unite(Coil_27, Coil_51)
  Coil_4.unite(Coil_28, Coil_52)
  Coil_5.unite(Coil_29, Coil_53)
  Coil_6.unite(Coil_30, Coil_54)
  Coil_7.unite(Coil_31, Coil_55)
  Coil_8.unite(Coil_32, Coil_56)
  Coil_9.unite(Coil_33, Coil_57)
  Coil_10.unite(Coil_34, Coil_58)
  Coil_11.unite(Coil_35, Coil_59)
  Coil_12.unite(Coil_36, Coil_60)
  Coil_13.unite(Coil_37, Coil_61)
  Coil_14.unite(Coil_38, Coil_62)
  Coil_15.unite(Coil_39, Coil_63)
  Coil_16.unite(Coil_40, Coil_64)
  Coil_17.unite(Coil_41, Coil_65)
  Coil_18.unite(Coil_42, Coil_66)
  Coil_19.unite(Coil_43, Coil_67)
  Coil_20.unite(Coil_44, Coil_68)
  Coil_21.unite(Coil_45, Coil_69)
  Coil_22.unite(Coil_46, Coil_70)
  Coil_23.unite(Coil_47, Coil_71)
  CoilRe_0 [copper] = user_primitive(RMxprt/LapCoil, DiaGap=762mm, DiaYoke=1102.2mm, Length=0mm, Skew=0deg, Slots=72, SlotType=6, Hs0=0.8mm, Hs1=3.2mm, Hs2=67mm, Bs0=14.7mm, Bs1=14.7mm, Bs2=14.7mm, Rs=0mm, FilletType=0, Layers=2, CoilPitch=10, EndExt=105mm, SpanExt=0mm, BendAngle=0deg, SegAngle=10deg, LenRegion=0mm, InfoCoil=3)
  CoilRe_0.rotate(axis=Z, angle=-50deg)
  CoilRe_1..CoilRe_23 [copper], CoilRe_24..CoilRe_71 = CoilRe_0.duplicate_around_axis(axis=Z, angle=5deg, total=72)
  CoilRe_0.unite(CoilRe_24, CoilRe_48)
  CoilRe_1.unite(CoilRe_25, CoilRe_49)
  CoilRe_2.unite(CoilRe_26, CoilRe_50)
  CoilRe_3.unite(CoilRe_27, CoilRe_51)
  CoilRe_4.unite(CoilRe_28, CoilRe_52)
  CoilRe_5.unite(CoilRe_29, CoilRe_53)
  CoilRe_6.unite(CoilRe_30, CoilRe_54)
  CoilRe_7.unite(CoilRe_31, CoilRe_55)
  CoilRe_8.unite(CoilRe_32, CoilRe_56)
  CoilRe_9.unite(CoilRe_33, CoilRe_57)
  CoilRe_10.unite(CoilRe_34, CoilRe_58)
  CoilRe_11.unite(CoilRe_35, CoilRe_59)
  CoilRe_12.unite(CoilRe_36, CoilRe_60)
  CoilRe_13.unite(CoilRe_37, CoilRe_61)
  CoilRe_14.unite(CoilRe_38, CoilRe_62)
  CoilRe_15.unite(CoilRe_39, CoilRe_63)
  CoilRe_16.unite(CoilRe_40, CoilRe_64)
  CoilRe_17.unite(CoilRe_41, CoilRe_65)
  CoilRe_18.unite(CoilRe_42, CoilRe_66)
  CoilRe_19.unite(CoilRe_43, CoilRe_67)
  CoilRe_20.unite(CoilRe_44, CoilRe_68)
  CoilRe_21.unite(CoilRe_45, CoilRe_69)
  CoilRe_22.unite(CoilRe_46, CoilRe_70)
  CoilRe_23.unite(CoilRe_47, CoilRe_71)
  Rotor [steel_1008_2DSF0.995] = user_primitive(RMxprt/SalientPoleCore, DiaGap=749mm, DiaYoke=250mm, Length=0mm, Skew=0deg, Slots=6, SlotType=1, Hs0=0.8mm, Hs01=0mm, Hs1=0mm, Hs2=0mm, Bs0=3mm, Bs1=14mm, Bs2=14mm, Rs=7mm, FilletType=0, SlotPitch=5.064deg, CenterPitch=14.736deg, Poles=6, PoleType=1, WidthShoe=280mm, HeightShoe=53mm, WidthBody=146mm, HeightBody=147mm, AirGap2=0mm, Offset=43mm, Off2_x=0mm, Off2_y=0mm, Bp1/Rp1=0mm, Bp2/Rp2=0mm, CoilEndExt=43mm, EndRingType=1, BarEndExt=0mm, RingLength=40mm, RingHeight=21mm, SegAngle=15deg, LenRegion=0mm, InfoCore=0)
  Field_0 [copper] = user_primitive(RMxprt/SalientPoleCore, DiaGap=749mm, DiaYoke=250mm, Length=0mm, Skew=0deg, Slots=6, SlotType=1, Hs0=0.8mm, Hs01=0mm, Hs1=0mm, Hs2=0mm, Bs0=3mm, Bs1=14mm, Bs2=14mm, Rs=7mm, FilletType=0, SlotPitch=5.064deg, CenterPitch=14.736deg, Poles=6, PoleType=1, WidthShoe=280mm, HeightShoe=53mm, WidthBody=146mm, HeightBody=147mm, AirGap2=0mm, Offset=43mm, Off2_x=0mm, Off2_y=0mm, Bp1/Rp1=0mm, Bp2/Rp2=0mm, CoilEndExt=43mm, EndRingType=1, BarEndExt=0mm, RingLength=40mm, RingHeight=21mm, SegAngle=15deg, LenRegion=0mm, InfoCore=4)
  Field_1 [copper], Field_2..Field_5 = Field_0.duplicate_around_axis(axis=Z, angle=60deg, total=6)
  Field_0.unite(Field_2, Field_4)
  Field_1.unite(Field_3, Field_5)
  FieldRe_0 [copper] = user_primitive(RMxprt/SalientPoleCore, DiaGap=749mm, DiaYoke=250mm, Length=0mm, Skew=0deg, Slots=6, SlotType=1, Hs0=0.8mm, Hs01=0mm, Hs1=0mm, Hs2=0mm, Bs0=3mm, Bs1=14mm, Bs2=14mm, Rs=7mm, FilletType=0, SlotPitch=5.064deg, CenterPitch=14.736deg, Poles=6, PoleType=1, WidthShoe=280mm, HeightShoe=53mm, WidthBody=146mm, HeightBody=147mm, AirGap2=0mm, Offset=43mm, Off2_x=0mm, Off2_y=0mm, Bp1/Rp1=0mm, Bp2/Rp2=0mm, CoilEndExt=43mm, EndRingType=1, BarEndExt=0mm, RingLength=40mm, RingHeight=21mm, SegAngle=15deg, LenRegion=0mm, InfoCore=5)
  FieldRe_1 [copper], FieldRe_2..FieldRe_5 = FieldRe_0.duplicate_around_axis(axis=Z, angle=60deg, total=6)
  FieldRe_0.unite(FieldRe_2, FieldRe_4)
  FieldRe_1.unite(FieldRe_3, FieldRe_5)
  Bar [copper_115C] = user_primitive(RMxprt/SalientPoleCore, DiaGap=749mm, DiaYoke=250mm, Length=0mm, Skew=0deg, Slots=6, SlotType=1, Hs0=0.8mm, Hs01=0.8mm, Hs1=0mm, Hs2=0mm, Bs0=3mm, Bs1=14mm, Bs2=14mm, Rs=7mm, FilletType=0, SlotPitch=5.064deg, CenterPitch=14.736deg, Poles=6, PoleType=1, WidthShoe=280mm, HeightShoe=53mm, WidthBody=146mm, HeightBody=147mm, AirGap2=0mm, Offset=43mm, Off2_x=0mm, Off2_y=0mm, Bp1/Rp1=0mm, Bp2/Rp2=0mm, CoilEndExt=43mm, EndRingType=1, BarEndExt=0mm, RingLength=40mm, RingHeight=21mm, SegAngle=15deg, LenRegion=0mm, InfoCore=3)
  Bar.split(plane=ZX, keep=PositiveOnly)
  Bar.rotate(axis=Z, angle=120deg)
  Bar.split(plane=ZX, keep=PositiveOnly)
  Bar.rotate(axis=Z, angle=-120deg)
  Bar_1 [copper_115C] = Bar.duplicate_around_axis(axis=Z, angle=60deg, total=2)
  Tool_1 = Tool.copy()
  Bar.subtract(Tool_1)
  Bar_Separate1..Bar_Separate5 [copper_115C] = Bar.separate_bodies()
  Tool_2 = Tool.copy()
  Bar_1.subtract(Tool_2)
  Bar_1_Separate1..Bar_1_Separate5 [copper_115C] = Bar_1.separate_bodies()
  InnerRegion [vacuum] = user_primitive(RMxprt/SalientPoleCore, DiaGap=749mm, DiaYoke=250mm, Length=0mm, Skew=0deg, Slots=6, SlotType=1, Hs0=0.8mm, Hs01=0mm, Hs1=0mm, Hs2=0mm, Bs0=3mm, Bs1=14mm, Bs2=14mm, Rs=7mm, FilletType=0, SlotPitch=5.064deg, CenterPitch=14.736deg, Poles=6, PoleType=1, WidthShoe=280mm, HeightShoe=53mm, WidthBody=146mm, HeightBody=147mm, AirGap2=0mm, Offset=43mm, Off2_x=0mm, Off2_y=0mm, Bp1/Rp1=0mm, Bp2/Rp2=0mm, CoilEndExt=43mm, EndRingType=1, BarEndExt=0mm, RingLength=40mm, RingHeight=21mm, SegAngle=15deg, LenRegion=0mm, InfoCore=100)
  Tool_3 = Tool.copy()
  Band.subtract(Tool_3)
  Tool_4 = Tool.copy()
  InnerRegion.subtract(Tool_4)
  Tool_5 = Tool.copy()
  Shaft.subtract(Tool_5)
  Tool_6 = Tool.copy()
  Stator.subtract(Tool_6)
  Tool_7 = Tool.copy()
  Coil_0.subtract(Tool_7)
  Tool_8 = Tool.copy()
  Coil_1.subtract(Tool_8)
  Tool_9 = Tool.copy()
  Coil_2.subtract(Tool_9)
  Tool_10 = Tool.copy()
  Coil_3.subtract(Tool_10)
  Tool_11 = Tool.copy()
  Coil_4.subtract(Tool_11)
  Tool_12 = Tool.copy()
  Coil_5.subtract(Tool_12)
  Tool_13 = Tool.copy()
  Coil_6.subtract(Tool_13)
  Tool_14 = Tool.copy()
  Coil_7.subtract(Tool_14)
  Tool_15 = Tool.copy()
  Coil_8.subtract(Tool_15)
  Tool_16 = Tool.copy()
  Coil_9.subtract(Tool_16)
  Tool_17 = Tool.copy()
  Coil_10.subtract(Tool_17)
  Tool_18 = Tool.copy()
  Coil_11.subtract(Tool_18)
  Tool_19 = Tool.copy()
  Coil_12.subtract(Tool_19)
  Tool_20 = Tool.copy()
  Coil_13.subtract(Tool_20)
  Tool_21 = Tool.copy()
  Coil_14.subtract(Tool_21)
  Tool_22 = Tool.copy()
  Coil_15.subtract(Tool_22)
  Tool_23 = Tool.copy()
  Coil_16.subtract(Tool_23)
  Tool_24 = Tool.copy()
  Coil_17.subtract(Tool_24)
  Tool_25 = Tool.copy()
  Coil_18.subtract(Tool_25)
  Tool_26 = Tool.copy()
  Coil_19.subtract(Tool_26)
  Tool_27 = Tool.copy()
  Coil_20.subtract(Tool_27)
  Tool_28 = Tool.copy()
  Coil_21.subtract(Tool_28)
  Tool_29 = Tool.copy()
  Coil_22.subtract(Tool_29)
  Tool_30 = Tool.copy()
  Coil_23.subtract(Tool_30)
  Tool_31 = Tool.copy()
  CoilRe_0.subtract(Tool_31)
  Tool_32 = Tool.copy()
  CoilRe_1.subtract(Tool_32)
  Tool_33 = Tool.copy()
  CoilRe_2.subtract(Tool_33)
  Tool_34 = Tool.copy()
  CoilRe_3.subtract(Tool_34)
  Tool_35 = Tool.copy()
  CoilRe_4.subtract(Tool_35)
  Tool_36 = Tool.copy()
  CoilRe_5.subtract(Tool_36)
  Tool_37 = Tool.copy()
  CoilRe_6.subtract(Tool_37)
  Tool_38 = Tool.copy()
  CoilRe_7.subtract(Tool_38)
  Tool_39 = Tool.copy()
  CoilRe_8.subtract(Tool_39)
  Tool_40 = Tool.copy()
  CoilRe_9.subtract(Tool_40)
  Tool_41 = Tool.copy()
  CoilRe_10.subtract(Tool_41)
  Tool_42 = Tool.copy()
  CoilRe_11.subtract(Tool_42)
  Tool_43 = Tool.copy()
  CoilRe_12.subtract(Tool_43)
  Tool_44 = Tool.copy()
  CoilRe_13.subtract(Tool_44)
  Tool_45 = Tool.copy()
  CoilRe_14.subtract(Tool_45)
  Tool_46 = Tool.copy()
  CoilRe_15.subtract(Tool_46)
  Tool_47 = Tool.copy()
  CoilRe_16.subtract(Tool_47)
  Tool_48 = Tool.copy()
  CoilRe_17.subtract(Tool_48)
  Tool_49 = Tool.copy()
  CoilRe_18.subtract(Tool_49)
  Tool_50 = Tool.copy()
  CoilRe_19.subtract(Tool_50)
  Tool_51 = Tool.copy()
  CoilRe_20.subtract(Tool_51)
  Tool_52 = Tool.copy()
  CoilRe_21.subtract(Tool_52)
  Tool_53 = Tool.copy()
  CoilRe_22.subtract(Tool_53)
  Tool_54 = Tool.copy()
  CoilRe_23.subtract(Tool_54)
  Tool_55 = Tool.copy()
  Rotor.subtract(Tool_55)
  Tool_56 = Tool.copy()
  Field_0.subtract(Tool_56)
  Tool_57 = Tool.copy()
  Field_1.subtract(Tool_57)
  Tool_58 = Tool.copy()
  FieldRe_0.subtract(Tool_58)
  FieldRe_1.subtract(Tool)
motion:
  MotionSetup1: Band Move_Type=Rotate Coordinate_System=Global Axis=Z Is_Positive=true InitPos=65deg Angular_Velocity=1000rpm Objects=Band
  Moving1: Moving Objects=[Shaft, Rotor, Field_0, Field_1, FieldRe_0, FieldRe_1, Bar, Bar_1, Bar_Separate1..Bar_Separate5, Bar_1_Separate1..Bar_1_Separate5, InnerRegion]
boundaries and excitations:
  VectorPotential1: Vector Potential Edges=OuterRegion.edge(at (275.55, 477.267, 0)) Value=0
  Master1: Master Edges=OuterRegion.edge(at (275.55, 0, 0))
  Slave1: Slave Edges=OuterRegion.edge(at (-137.775, 238.633, 0)) ReverseU master=Master1 SameAsMaster=true
  PhA_0: Coil Objects=Coil_0 Conductor_number=conds Winding=PhaseA PolarityType=Positive
  PhARe_0: Coil Objects=CoilRe_10 Conductor_number=conds Winding=PhaseA PolarityType=Negative
  PhA_1: Coil Objects=Coil_1 Conductor_number=conds Winding=PhaseA PolarityType=Positive
  PhARe_1: Coil Objects=CoilRe_11 Conductor_number=conds Winding=PhaseA PolarityType=Negative
  PhA_2: Coil Objects=Coil_2 Conductor_number=conds Winding=PhaseA PolarityType=Positive
  PhARe_2: Coil Objects=CoilRe_12 Conductor_number=conds Winding=PhaseA PolarityType=Negative
  PhA_3: Coil Objects=Coil_3 Conductor_number=conds Winding=PhaseA PolarityType=Positive
  PhARe_3: Coil Objects=CoilRe_13 Conductor_number=conds Winding=PhaseA PolarityType=Negative
  PhCRe_4: Coil Objects=Coil_4 Conductor_number=conds Winding=PhaseC PolarityType=Negative
  PhC_4: Coil Objects=CoilRe_14 Conductor_number=conds Winding=PhaseC PolarityType=Positive
  PhCRe_5: Coil Objects=Coil_5 Conductor_number=conds Winding=PhaseC PolarityType=Negative
  PhC_5: Coil Objects=CoilRe_15 Conductor_number=conds Winding=PhaseC PolarityType=Positive
  PhCRe_6: Coil Objects=Coil_6 Conductor_number=conds Winding=PhaseC PolarityType=Negative
  PhC_6: Coil Objects=CoilRe_16 Conductor_number=conds Winding=PhaseC PolarityType=Positive
  PhCRe_7: Coil Objects=Coil_7 Conductor_number=conds Winding=PhaseC PolarityType=Negative
  PhC_7: Coil Objects=CoilRe_17 Conductor_number=conds Winding=PhaseC PolarityType=Positive
  PhB_8: Coil Objects=Coil_8 Conductor_number=conds Winding=PhaseB PolarityType=Positive
  PhBRe_8: Coil Objects=CoilRe_18 Conductor_number=conds Winding=PhaseB PolarityType=Negative
  PhB_9: Coil Objects=Coil_9 Conductor_number=conds Winding=PhaseB PolarityType=Positive
  PhBRe_9: Coil Objects=CoilRe_19 Conductor_number=conds Winding=PhaseB PolarityType=Negative
  PhB_10: Coil Objects=Coil_10 Conductor_number=conds Winding=PhaseB PolarityType=Positive
  PhBRe_10: Coil Objects=CoilRe_20 Conductor_number=conds Winding=PhaseB PolarityType=Negative
  PhB_11: Coil Objects=Coil_11 Conductor_number=conds Winding=PhaseB PolarityType=Positive
  PhBRe_11: Coil Objects=CoilRe_21 Conductor_number=conds Winding=PhaseB PolarityType=Negative
  PhARe_12: Coil Objects=Coil_12 Conductor_number=conds Winding=PhaseA PolarityType=Negative
  PhA_12: Coil Objects=CoilRe_22 Conductor_number=conds Winding=PhaseA PolarityType=Positive
  PhARe_13: Coil Objects=Coil_13 Conductor_number=conds Winding=PhaseA PolarityType=Negative
  PhA_13: Coil Objects=CoilRe_23 Conductor_number=conds Winding=PhaseA PolarityType=Positive
  PhARe_14: Coil Objects=Coil_14 Conductor_number=conds Winding=PhaseA PolarityType=Negative
  PhARe_15: Coil Objects=Coil_15 Conductor_number=conds Winding=PhaseA PolarityType=Negative
  PhC_16: Coil Objects=Coil_16 Conductor_number=conds Winding=PhaseC PolarityType=Positive
  PhC_17: Coil Objects=Coil_17 Conductor_number=conds Winding=PhaseC PolarityType=Positive
  PhC_18: Coil Objects=Coil_18 Conductor_number=conds Winding=PhaseC PolarityType=Positive
  PhC_19: Coil Objects=Coil_19 Conductor_number=conds Winding=PhaseC PolarityType=Positive
  PhBRe_20: Coil Objects=Coil_20 Conductor_number=conds Winding=PhaseB PolarityType=Negative
  PhBRe_21: Coil Objects=Coil_21 Conductor_number=conds Winding=PhaseB PolarityType=Negative
  PhBRe_22: Coil Objects=Coil_22 Conductor_number=conds Winding=PhaseB PolarityType=Negative
  PhBRe_23: Coil Objects=Coil_23 Conductor_number=conds Winding=PhaseB PolarityType=Negative
  PhA_62: Coil Objects=CoilRe_0 Conductor_number=conds Winding=PhaseA PolarityType=Positive
  PhA_63: Coil Objects=CoilRe_1 Conductor_number=conds Winding=PhaseA PolarityType=Positive
  PhCRe_64: Coil Objects=CoilRe_2 Conductor_number=conds Winding=PhaseC PolarityType=Negative
  PhCRe_65: Coil Objects=CoilRe_3 Conductor_number=conds Winding=PhaseC PolarityType=Negative
  PhCRe_66: Coil Objects=CoilRe_4 Conductor_number=conds Winding=PhaseC PolarityType=Negative
  PhCRe_67: Coil Objects=CoilRe_5 Conductor_number=conds Winding=PhaseC PolarityType=Negative
  PhB_68: Coil Objects=CoilRe_6 Conductor_number=conds Winding=PhaseB PolarityType=Positive
  PhB_69: Coil Objects=CoilRe_7 Conductor_number=conds Winding=PhaseB PolarityType=Positive
  PhB_70: Coil Objects=CoilRe_8 Conductor_number=conds Winding=PhaseB PolarityType=Positive
  PhB_71: Coil Objects=CoilRe_9 Conductor_number=conds Winding=PhaseB PolarityType=Positive
  Field_0: Coil Objects=Field_0 Conductor_number=67.5 Winding=Field PolarityType=Positive
  FieldRe_0: Coil Objects=FieldRe_0 Conductor_number=67.5 Winding=Field PolarityType=Negative
  FieldRe_1: Coil Objects=Field_1 Conductor_number=67.5 Winding=Field PolarityType=Negative
  Field_1: Coil Objects=FieldRe_1 Conductor_number=67.5 Winding=Field PolarityType=Positive
  EndConnection1: End Connection Objects=[Bar, Bar_Separate1..Bar_Separate5] ResistanceValue=0ohm InductanceValue=0H
  EndConnection2: End Connection Objects=[Bar_1, Bar_1_Separate1..Bar_1_Separate5] ResistanceValue=0ohm InductanceValue=0H
  PhaseA: Winding Group Type=Voltage IsSolid=false Current=0A Resistance=R1 Inductance=Le1 Voltage=5388.88*sin(2*pi*50*time+delta) ParallelBranchesNum=1
  PhaseB: Winding Group Type=Voltage IsSolid=false Current=0A Resistance=R1 Inductance=Le1 Voltage=5388.88*sin(2*pi*50*time+delta-2*pi/3) ParallelBranchesNum=1
  PhaseC: Winding Group Type=Voltage IsSolid=false Current=0A Resistance=R1 Inductance=Le1 Voltage=5388.88*sin(2*pi*50*time+delta-4*pi/3) ParallelBranchesNum=1
  Field: Winding Group Type=Current IsSolid=false Current=248.49A ParallelBranchesNum=1
  Y connection: PhaseA, PhaseB, PhaseC
mesh:
  SurfApprox_Bar: SurfApproxBased Objects=[Bar, Bar_Separate1..Bar_Separate5, Bar_1, Bar_1_Separate1..Bar_1_Separate5] CurvedSurfaceApproxChoice=ManualSettings SurfDev=0.3745mm NormalDev=15deg
  SurfApprox_Main: SurfApproxBased Objects=[Stator, Rotor, Band, OuterRegion, InnerRegion, Shaft] CurvedSurfaceApproxChoice=ManualSettings SurfDev=0.5511mm NormalDev=15deg
  initial mesh: MeshMethod=AnsoftTAU
setups:
  Setup1: Transient NonlinearSolverResidual=0.0001 StopTime=0.2s TimeStep=0.0002s FastReachSteadyState AutoDetectSteadyState FrequencyOfAddedVoltageSource=50Hz StopCriterion=0.005 InitialTimeStep=0.002s MinTimeStep=0.001s MaxTimeStep=0.003s TimeStepErrTolerance=0.0001
output variables:
  pos = (Moving1.Position -65 * PI/180) * 3 + PI
  cos0 = cos(pos)
  cos1 = cos(pos-2*PI/3)
  cos2 = cos(pos-4*PI/3)
  sin0 = sin(pos)
  sin1 = sin(pos-2*PI/3)
  sin2 = sin(pos-4*PI/3)
  Lad = L(PhaseA,PhaseA)*cos0 + L(PhaseA,PhaseB)*cos1 + L(PhaseA,PhaseC)*cos2
  Laq = L(PhaseA,PhaseA)*sin0 + L(PhaseA,PhaseB)*sin1 + L(PhaseA,PhaseC)*sin2
  Lbd = L(PhaseB,PhaseA)*cos0 + L(PhaseB,PhaseB)*cos1 + L(PhaseB,PhaseC)*cos2
  Lbq = L(PhaseB,PhaseA)*sin0 + L(PhaseB,PhaseB)*sin1 + L(PhaseB,PhaseC)*sin2
  Lcd = L(PhaseC,PhaseA)*cos0 + L(PhaseC,PhaseB)*cos1 + L(PhaseC,PhaseC)*cos2
  Lcq = L(PhaseC,PhaseA)*sin0 + L(PhaseC,PhaseB)*sin1 + L(PhaseC,PhaseC)*sin2
  L_d = (Lad*cos0 + Lbd*cos1 + Lcd*cos2) * 2/3
  L_q = (Laq*sin0 + Lbq*sin1 + Lcq*sin2) * 2/3
  Flux_d = (FluxLinkage(PhaseA)*cos0+FluxLinkage(PhaseB)*cos1+FluxLinkage(PhaseC)*cos2)*2/3
  Flux_q = (FluxLinkage(PhaseA)*sin0+FluxLinkage(PhaseB)*sin1+FluxLinkage(PhaseC)*sin2)*2/3
  I_d = (Current(PhaseA)*cos0 + Current(PhaseB)*cos1 + Current(PhaseC)*cos2)*2/3
  I_q = (Current(PhaseA)*sin0 + Current(PhaseB)*sin1 + Current(PhaseC)*sin2)*2/3
  Irms = sqrt(I_d^2+I_q^2)/sqrt(2)
  Pcu = 3*Irms^2*0
reports:
  Torque: Moving1.Torque vs Time on Setup1 : Transient
  Currents: Current(PhaseA), Current(PhaseB), Current(PhaseC) vs Time on Setup1 : Transient
  Induced Voltages: InducedVoltage(PhaseA), InducedVoltage(PhaseB), InducedVoltage(PhaseC) vs Time on Setup1 : Transient
  Flux Linkages: FluxLinkage(PhaseA), FluxLinkage(PhaseB), FluxLinkage(PhaseC) vs Time on Setup1 : Transient
  Voltages: InputVoltage(PhaseA), InputVoltage(PhaseB), InputVoltage(PhaseC) vs Time on Setup1 : Transient
  Powers: InputVoltage(PhaseA)*Current(PhaseA) + InputVoltage(PhaseB)*Current(PhaseB) + InputVoltage(PhaseC)*Current(PhaseC), Moving1.Speed*Moving1.Torque vs Time on Setup1 : Transient
  L_dq: L_d, L_q vs Time on Setup1 : Transient
  Flux_dq: Flux_d, Flux_q vs Time on Setup1 : Transient
  I_dq: I_d, I_q vs Time on Setup1 : Transient
