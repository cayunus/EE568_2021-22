# Ansys Electronics Desktop project, version 2020.2
materials:
  copper_75C: permeability=0.999991 conductivity=46000000
  M22_24G: permeability{HUnit=A_per_meter BUnit=tesla curve (0, 0) (160, 0.8) (240, 1) (320, 1.1) (420, 1.2) (680, 1.3) (810, 1.325) (1100, 1.375) (1400, 1.4) (2600, 1.475) (4200, 1.54) (5087.91, 1.575) (6579.41, 1.625) (8231.91, 1.675) (10258.9, 1.725) (13348.9, 1.775) (18788.9, 1.825) (28908.9, 1.875) (46508.9, 1.925) (74308.9, 1.975) (129350, 2.05) (248716, 2.2) (447658, 2.45) (726178, 2.8)} conductivity=2000000 core_loss_type="Electrical Steel" core_loss_kh=177.7 core_loss_kc=1.33 core_loss_ke=1.22 mass_density=7650
  steel_1008: permeability{HUnit=A_per_meter BUnit=tesla curve (0, 0) (159.2, 0.2402) (318.3, 0.8654) (477.5, 1.1106) (636.6, 1.2458) (795.8, 1.331) (1591.5, 1.5) (3183.1, 1.6) (4774.6, 1.683) (6366.2, 1.741) (7957.7, 1.78) (15915.5, 1.905) (31831, 2.025) (47746.5, 2.085) (63662, 2.13) (79577.5, 2.165) (159155, 2.28) (318310, 2.485) (397887, 2.5851)} conductivity=2000000 mass_density=7872

design bjs10-61 (RMxprt, Three Phase Synchronous Machine, model units mm)
machine:
  Machine: FrictionLoss=100kW WindLoss=80kW ReferenceSpeed=187.5rpm NumberOfPoles=32
  Stator: SkewWidth=0 NumberOfSlots=300 LaminationSectors=1 PressBoardThickness=0mm OuterDiameter=5974mm InnerDiameter=5431mm Length=1066mm StackingFactor=0.9 SteelType=M22_24G SlotType=6
  Rotor: OuterDiameter=5398mm InnerDiameter=1800mm Length=1066mm SteelType=steel_1008 SecondAirGap=0mm PoleBodyHeight=260mm PoleShoeHeight=30mm Off2x=0mm Off2y=0mm PoleArcOffset=10mm PoleBodyWidth=240mm PoleShoeWidth=350mm PoleStackingFactor=0.96 PoleSteelType=M22_24G PressBoardThickness=40mm StackingFactor=0.96 ShoeInsulation=1.5mm PoleInsulation=1.5mm WindingClearance=1mm
  Shaft:
  Stator Slot: Hs0=1mm Hs1=4.2mm Hs2=120mm Bs0=0mm Bs1=22.7mm Bs2=22.7mm Rs=0mm ToothWidth=0mm
  Stator Winding: WindingType=Whole-Coiled WindingLayers=2 ParallelBranches=1 ConductorsPerSlot=2 CoilPitch=9 EndAdjustment=150mm BaseInnerRadius=0mm TipInnerDiameter=30mm EndClearance=5mm CoilWrap=2mm SlotLiner=1.2mm WedgeThickness=4mm LayerInsulation=2mm BottomInsulation=0mm LimitedFillFactor=0.75 WdgNumberofPriodicMultipler=1 NumberOfStrands=0 WireWrap=0mm InterturnInsulation=0mm WireDiameter=0mm WireWidth=0mm WireThickness=0mm Gauge=STANDARDRECT
  Rotor Winding: WindingType=EdgewiseCoil ParallelBranches=1 ConductorsPerPole=20 AxialClearance=0mm LimitedCrossWidth=0mm LimitedCrossHeight=0mm NumberOfStrands=1 WireWrap=0.2mm InterturnInsulation=0.4mm WireDiameter=0mm WireWidth=60mm WireThickness=16mm Gauge=USER WindingFillet=0mm
  Stator Vent: VentDucts=10 DuctWidth=9.5mm MagneticSpacerWidth=0mm DuctPitch=0mm
  Rotor Damper: DamperSlotsPerPole=6 SlotType=1 BarConductorType=copper_75C EndLength=0mm EndRingWidth=12.5mm EndRingHeight=21mm EndRingConductorType=copper_75C SlotPitch=1deg CenterSlotPitch=2deg EndRingType=1
  Damper Slot: Hs0=0.8mm Hs1=0mm Hs2=0mm Bs0=3mm Bs1=10mm Bs2=10mm Rs=0mm Hs01=0mm
setups:
  Setup1: SYNM Generator RatedOutputPower=44000 RatedVoltage=13800V RatedSpeed=187.5rpm OperatingTemperature=85cel LoadType=InfiniteBus RatedPowerFactor=0.9 ExciterEfficiency=90 StartingFieldResistance=0ohm
