# Ansys Electronics Desktop project, version 2020.2
materials:
  M19_24G: permeability{HUnit=A_per_meter BUnit=tesla curve (0, 0) (22.28, 0.05) (25.46, 0.1) (31.83, 0.15) (47.74, 0.36) (63.66, 0.54) (79.57, 0.65) (159.15, 0.99) (318.3, 1.2) (477.46, 1.28) (636.61, 1.33) (795.77, 1.36) (1591.5, 1.44) (3183, 1.52) (4774.6, 1.58) (6366.1, 1.63) (7957.7, 1.67) (15915, 1.8) (31830, 1.9) (111407, 2) (190984, 2.1) (350138, 2.3) (509292, 2.5)} conductivity=1960000 core_loss_type="Electrical Steel" core_loss_kh=164.2 core_loss_kc=1.3 core_loss_ke=1.72 mass_density=7650
  copper: permeability=0.999991 conductivity=58000000 mass_density=8933

design RMxprtDesign1 (RMxprt, Generic Rotating Machines, model units mm)
machine:
  Machine: RotorType=4 StatorType=0 SourceType=0 Structure=0 ImportRotor=0 ImportStator=0 StatorCenter=0 RotorCenter=0 ImportType MasterSlaveOnXais Fraction=0 AirGapLength=0mm DoubleSided=0
  Stator: NumberOfPoles=32 NumberOfSlots=300 SlotType=6 CircuitType=0
  Rotor: NumberOfPoles=32
  Shaft: FrictionLoss=100W WindLoss=100W ReferenceSpeed=187.5rpm
  Stator Core: OuterDiameter=6600mm InnerDiameter=5700mm Length=1100mm SteelType=M19_24G StackingFactor=0.95 LaminationSectors=0 PressBoardThickness=0mm SkewWidth=0deg
  Stator Winding: WindingType=Whole-Coiled WindingLayers=2 ParallelBranches=1 ConductorsPerSlot=2 CoilPitch=9 EndAdjustment=300mm BaseInnerRadius=0mm TipInnerDiameter=0mm EndClearance=1mm CoilWrap=0mm SlotLiner=2mm WedgeThickness=2mm LayerInsulation=0mm BottomInsulation=0mm LimitedFillFactor=0.75 WdgNumberofPriodicMultipler=1 NumberOfStrands=10 WireWrap=0mm InterturnInsulation=0mm WireDiameter=0mm WireWidth=0mm WireThickness=0mm Gauge=STANDARDRECT CorrectionFactor=1 TopSpareSpace=0 BottomSpareSpace=0 ConductorType=copper
  Rotor Core: OuterDiameter=5670mm InnerDiameter=1500mm Length=1100mm SteelType=M19_24G StackingFactor=0.95 PressBoardThickness=0mm SkewWidth=0deg PoleType=1
  Rotor Field: ShoeInsulation=1mm PoleInsulation=1mm WindingClearance=0.1mm ExciterEfficiency=90 ExcitingCurrent=800A
  Core Slot: Hs0=3mm Hs1=6mm Hs2=0mm Bs0=0mm Bs1=0mm Bs2=0mm Rs=0mm AutoDesign ToothWidth=0mm
  Core Pole: SecondAirGap=0mm PoleBodyHeight=400mm PoleShoeHeight=50mm Off2x=0mm Off2y=0mm PoleArcOffset=0mm PoleBodyWidth=270mm PoleShoeWidth=340mm PoleStackingFactor=0.97 PoleSteelType=M19_24G Bp1/Rp1=0mm Bp2/Rp2=0mm Bp2/RP2=0mm
  Field Winding: WindingType=EdgewiseCoil AxiClearance=0mm ConductorsPerPole=0 InterturnInsulation=0mm LimitedCrossHeight=0mm LimitedCrossWidth=0mm NumOfStrands=0 ParallelBranches=1 WindingFillet=0mm WireSize=0mm WireWrap=0mm ConductorType=copper NumberOfStrands=0 WireDiameter=0mm WireWidth=0mm WireThickness=0mm Gauge=AUTO
setups:
  SalientPoleSG: GRM Generator RatedOutputPower=44000 RatedVoltage=13.8kV RatedSpeed=187.5rpm OperatingTemperature=85cel LoadType=InfiniteBus RatedPowerFactor=0.9 Frequency=50Hz
